ADE simulation setup
Test Mini_Project_1_testbench_final_1: Mini_Project_1/testbench_final/schematic, simulator spectre
  Models: /opt/cadence-designkits/gpdk045_v_5_0/gpdk045/../models/spectre/gpdk045.scs[mc]
  Variables: inv_fing = 1; AC_noise = 0; Rf = 670M; Rg = 10M; VDD = 2; AC_ripple = 0; AC_signal = 1; k = 100; L = 150n; M = 1; M_diffpair = 4; N = 1; R = 25k; V_cmfb_in = 1; V_ref = 1; vdd = 2; W = 500n
  Temperature: 27
  Analysis dc: (saves the operating point)
  Analysis ac: start=1 stop=1G
  Output v (/vout+ /vout-); dc (V) = (v("/vout+" ?result nil) - v("/vout-" ?result nil))
  Output vout = (vfreq('ac "/vout+") - vfreq('ac "/vout-")) (unticked)
  Output vin = (vfreq('ac "/net9") - vfreq('ac "/net8")) (unticked)
  Output speaker_in = (vfreq('ac "/speakerin_plus") - vfreq('ac "/speakerin_minus")) (unticked)
  Output speaker_out = vfreq('ac "/net4") (unticked)
  Output v /net15; ac mag(V) = vfreq('ac "/net15")
  Output v /net6; ac mag(V) = vfreq('ac "/net6")
  Output v /net13; ac mag(V) = vfreq('ac "/net13")
  Output v /net9; ac mag(V) = vfreq('ac "/net9")
  Output v /net8; ac mag(V) = vfreq('ac "/net8")
Run mode: Single Run, Sweeps and Corners
