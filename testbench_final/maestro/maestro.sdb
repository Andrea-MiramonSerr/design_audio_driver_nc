ADE simulation setup
Run mode: Single Run, Sweeps and Corners
Tests:
  Mini_Project_1_testbench_final_1: mini_project_1/testbench_final/schematic, simulator spectre
    Variables: AC_ripple = 0; AC_signal = 1; k = 100; L = 150n; M = 1; M_diffpair = 4; N = 1; R = 25k; V_cmfb_in = 1; V_ref = 1; vdd = 2; W = 500n; VDD = 2; Rf = 670M; Rg = 10M; AC_noise = 0; inv_fing = 1
    Outputs: vin
