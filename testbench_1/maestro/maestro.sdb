ADE simulation setup
Run mode: Single Run, Sweeps and Corners
Tests:
  Mini_Project_1_testbench_1_1: Mini_Project_1/testbench_1/schematic, simulator spectre
    Variables: A = 12; AC_noise = 0; AC_ripple = 0; AC_signal = 0; B = 500; C = 100; k = 100; vdd = 2; eg = 0
    Outputs: VF("/audio_out))) "); Output; Zin
Single Run, Sweeps and Corners options: submitpointsenabled=0
