ADE simulation setup
Test Mini_Project_1_testbench_final_1: Mini_Project_1/testbench_final/schematic, simulator spectre
  Models: /opt/cadence-designkits/gpdk045_v_5_0/gpdk045/../models/spectre/gpdk045.scs[mc]
  Variables: Rf = 1G; Rg = 1M; VDD = 2; AC_ripple = 0; AC_signal = 1; k = 100; L = 150n; M = 1; M_diffpair = 4; N = 1; R = 25k; V_cmfb_in = 1; V_ref = 1; vdd = 2; W = 500n
  Temperature: 27
  Analysis dc: (saves the operating point)
  Analysis ac: start=1 stop=1G
  Output v (/vout+ /vout-); dc (V) = (v("/vout+" ?result nil) - v("/vout-" ?result nil))
  Output vout = (vfreq('ac "/vout+") - vfreq('ac "/vout-"))
  Output vin = (vfreq('ac "/net9") - vfreq('ac "/net8"))
Run mode: Single Run, Sweeps and Corners
