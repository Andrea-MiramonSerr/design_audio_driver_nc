ADE simulation setup
Test Mini_Project_1_testbench_1_1: Mini_Project_1/testbench_1/schematic, simulator spectre
  Models: /opt/cadence-designkits/gpdk045_v_5_0/gpdk045/../models/spectre/gpdk045.scs[mc]
  Variables: eg = 0; A = 12; AC_noise = 0; AC_ripple = 0; AC_signal = 0; B = 500; C = 100; k = 30; vdd = 2
  Temperature: 27
  Analysis ac: start=1 stop=1G
  Analysis dc: (saves the operating point)
  Output Output = dB20(VF("/audio_out"))
  Output Zin = VF("/zin")
