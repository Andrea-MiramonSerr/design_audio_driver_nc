ADE simulation setup
Test Mini_Project_1_testbench_1_1: Mini_Project_1/testbench_1/schematic, simulator spectre
  Models: /opt/cadence-designkits/gpdk045_v_5_0/gpdk045/../models/spectre/gpdk045.scs[mc]
  Variables: eg = 0; A = 12; AC_noise = 0; AC_ripple = 0; AC_signal = 0; B = 500; C = 100; k = 100; vdd = 2
  Temperature: 27
  Analysis dc: (saves the operating point)
  Analysis ac: start=1 stop=1G
  Output Output = dB20(VF("/audio_out"))
  Output Zin = VF("/zin")
  Output v (/net1 /net17); ac mag(V) = (vfreq('ac "/net1") - vfreq('ac "/net17")) (unticked)
  Output SSF_input = (vfreq('ac "/net15") - vfreq('ac "/net17"))
  Output Differential_SSF_Output = (vfreq('ac "/net23") - vfreq('ac "/net1"))
  Output v (/net28 /net5); ac mag(V) = (vfreq('ac "/net28") - vfreq('ac "/net5"))
