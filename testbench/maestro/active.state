ADE simulation setup
Test Mini_Project_1_testbench_1: Mini_Project_1/testbench/schematic, simulator spectre
  Models: /opt/cadence-designkits/gpdk045_v_5_0/gpdk045/../models/spectre/gpdk045.scs[mc]
  Variables: Rf_B = 7M; Rg_B = 1M; N_bottom_pmosamp = 1; N_pmosamp = 1; N_tail_pmosamp = 1; inv_fing = 10; Rf = 69k; Rg = 1k; N_bottom = 1; N_top = 1; M1 = 1; M_diffpair1 = 4; k = 10; L = 150n; M = 2; M_diffpair = 4; N = 1; R = 25k; W = 500n; A = 75; AC_noise = 0; AC_ripple = 0; AC_signal = 1; B = 66; C = 10; vdd = 2
  Temperature: 27
  Analysis dc: (saves the operating point)
  Analysis ac: start=1 stop=1G
  Output v /audio_out; ac mag(V) = vfreq('ac "/audio_out")
  Output v /net8; ac mag(V) = vfreq('ac "/net8") (unticked)
  Output v /net7; ac mag(V) = vfreq('ac "/net7") (unticked)
  Output v /net6; ac mag(V) = vfreq('ac "/net6") (unticked)
  Output v /vdd; ac mag(V) = vfreq('ac "/vdd") (unticked)
  Output v (/net7 /net6); ac mag(V) = (vfreq('ac "/net7") - vfreq('ac "/net6"))
  Output Cc output = vfreq('ac "/Cc_output")
  Output v /Bc_output; ac mag(V) = vfreq('ac "/Bc_output")
  Output v (/net3 /net4); ac mag(V) = (vfreq('ac "/net3") - vfreq('ac "/net4"))
  Output v (/net24 /net4); ac mag(V) = (vfreq('ac "/net24") - vfreq('ac "/net4"))
  Output v (/net13 /net1); ac mag(V) = (vfreq('ac "/net13") - vfreq('ac "/net1"))
Run mode: Single Run, Sweeps and Corners
