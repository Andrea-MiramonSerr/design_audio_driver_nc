ADE simulation setup
Run mode: Single Run, Sweeps and Corners
Tests:
  Mini_Project_1_testbench_1: Mini_Project_1/testbench/schematic, simulator spectre
    Variables: A = 75; AC_noise = 0; AC_ripple = 0; AC_signal = 1; B = 66; C = 10; vdd = 2; k = 10; L = 150n; M = 2; M_diffpair = 4; N = 1; R = 25k; W = 500n; M1 = 1; M_diffpair1 = 4; N_top = 1; N_bottom = 1; inv_fing = 10; Rf = 69k; Rg = 1k; N_bottom_pmosamp = 1; N_pmosamp = 1; N_tail_pmosamp = 1; Rf_B = 7M; Rg_B = 1M
    Outputs: Cc output
