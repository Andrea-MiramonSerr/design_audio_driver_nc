ADE simulation setup
Run mode: Single Run, Sweeps and Corners
Tests:
  size_sweep: Mini_Project_1/Buffer/schematic, simulator spectre
    Variables: n = 100
    Outputs: gm
