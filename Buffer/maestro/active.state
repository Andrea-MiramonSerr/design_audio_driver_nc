ADE simulation setup
Test size_sweep: Mini_Project_1/Buffer/schematic, simulator spectre
  Models: /opt/cadence-designkits/gpdk045_v_5_0/gpdk045/../models/spectre/gpdk045.scs[mc]
  Variables: n = 100
  Temperature: 27
  Operating points saved: M0 (gm)
  Analysis dc: sweep n start=1 stop=100k (saves the operating point)
  Output gm = OS("M0" "gm")
Run mode: Single Run, Sweeps and Corners
