ADE simulation setup
Test Mini_Project_1_inverter_Bc_1: Mini_Project_1/inverter_Bc/schematic, simulator spectre
  Models: /opt/cadence-designkits/gpdk045_v_5_0/gpdk045/../models/spectre/gpdk045.scs[mc]
  Variables: R_bias = 10; vin_dc = 550m; Rf = 69k; Rg = 1k; k = 10
  Temperature: 27
  Analysis dc: (saves the operating point)
  Analysis ac: start=1 stop=1G
  Output v /vout; ac mag(V) = vfreq('ac "/vout")
Run mode: Single Run, Sweeps and Corners
