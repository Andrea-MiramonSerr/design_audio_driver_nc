ADE simulation setup
Run mode: Single Run, Sweeps and Corners
Tests:
  Mini_Project_1_inverter_Bc_1: Mini_Project_1/inverter_Bc/schematic, simulator spectre
    Variables: k = 10; Rf = 69k; Rg = 1k; vin_dc = 550m; R_bias = 10
